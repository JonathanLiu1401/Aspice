// Design: gpdk045_work/tb_port_mismatch
simulator lang=spectre
global 0
parameters W0=2u Lmin=180n
include "$PDK/models/spectre/gpdk045.scs" section=tt

subckt cs_amp vin vout vdd vss
    M0 (vout vin vss vss) nch w=W0 l=Lmin
    RD (vdd vout) resistor r=10k
ends cs_amp

// Fault: instance lists 3 nodes; subckt defines 4 ports
I0 (net1 net3 vdd) cs_amp
VIN (net1 0) vsource dc=0.7 mag=1 type=dc
VDD (vdd 0) vsource dc=1.8 type=dc

dcOp dc
