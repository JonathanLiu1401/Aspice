// Design: gpdk045_work/tb_analysis_bad_ref
simulator lang=spectre
global 0
parameters W0=2u Lmin=180n
include "$PDK/models/spectre/gpdk045.scs" section=tt

M0 (vout vin 0 0) nch w=W0 l=Lmin
RD (vdd vout) resistor r=10k
VIN (vin 0) vsource dc=0.7 mag=1 type=dc
VDD (vdd 0) vsource dc=1.8 type=dc

// Fault: noise oprobe and dc sweep device do not exist
dc1 dc dev=VGS param=dc start=0 stop=1.8 step=0.01
noise1 noise start=1 stop=1G dec=10 oprobe=Vmissing iprobe=VIN
