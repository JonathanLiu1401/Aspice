// Design: gpdk045_work/tb_missing_save
simulator lang=spectre
global 0
parameters W0=2u Lmin=180n
include "$PDK/models/spectre/gpdk045.scs" section=tt

M0 (vout vin 0 0) nch w=W0 l=Lmin
RD (vdd vout) resistor r=10k
VIN (vin 0) vsource dc=0.7 mag=1 type=dc
VDD (vdd 0) vsource dc=1.8 type=dc

simulatorOptions options temp=27
dcOp dc
ac1 ac start=1 stop=1G dec=10
// Fault: save=selected and no save statements. Wanted net vout is not listed.
saveOptions options save=selected currents=selected
