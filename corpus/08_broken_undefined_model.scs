// Design: gpdk045_work/tb_undefined_model
simulator lang=spectre
global 0
parameters W0=2u Lmin=180n

// Fault: master nch_missing is never defined by model or subckt
M0 (vout vin 0 0) nch_missing w=W0 l=Lmin
RD (vdd vout) resistor r=10k
VIN (vin 0) vsource dc=0.7 mag=1 type=dc
VDD (vdd 0) vsource dc=1.8 type=dc

dcOp dc
