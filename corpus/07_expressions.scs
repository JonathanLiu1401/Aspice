// Design: gpdk045_work/tb_expressions
simulator lang=spectre
global 0
parameters W0=1u Lmin=180n nf=2
include "$PDK/models/spectre/gpdk045.scs" section=tt

// gpdk045_work/tb_expressions/schematic
// Raw expressions kept as text: arithmetic, braces, and CDF pPar/VAR/iPar forms
M0 (vout vin 0 0) nch w=W0*2 l={Lmin} m=nf
M1 (vout vin 0 0) nch w=pPar("W") l=VAR("Lmin") nf=iPar("nf")
RD (vdd vout) resistor r=10k
VIN (vin 0) vsource dc=0.7 mag=1 type=dc
VDD (vdd 0) vsource dc=1.8 type=dc

simulatorOptions options temp=27
dcOp dc
ac1 ac start=1 stop=1G dec=10
save vout
