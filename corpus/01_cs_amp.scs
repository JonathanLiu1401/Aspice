// Design: gpdk045_work/tb_cs_amp
simulator lang=spectre
global 0
parameters W0=2u Lmin=180n VDD=1.8
include "$PDK/models/spectre/gpdk045.scs" section=tt

// gpdk045_work/cs_amp/schematic
subckt cs_amp vin vout vdd vss
    M0 (vout vin vss vss) nch w=2u l=180n
    RD (vdd vout) resistor r=10k
ends cs_amp

// gpdk045_work/tb_cs_amp/schematic
I0 (net1 net3 vdd 0) cs_amp
VIN (net1 0) vsource dc=0.7 mag=1 type=dc
VDD (vdd 0) vsource dc=1.8 type=dc

simulatorOptions options temp=27
dcOp dc
ac1 ac start=1 stop=1G dec=10
save I0:net3
